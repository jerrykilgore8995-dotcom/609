609 33609/JD discrete stereo limiter/compressor test fixture
.include devices.inc
.include transformers.inc
.include switches.inc
.include ex10340c.inc
.include ex11475.inc

.param AMP_L=1.095873 AMP_R=0 FREQ=1000 SOURCE=40 LOAD=600
.param ACTIVE=1 LINKED=0 POWER=1
.param CTL=1 CRL=1 CML=1 CGL=1 LTL=9 LRL=1 CEL=0 LEL=0 FASTL=0
.param CTR=1 CRR=1 CMR=1 CGR=1 LTR=9 LRR=1 CER=0 LER=0 FASTR=0
* Use tools/measure_jd_distortion.py for the alternative transformer fit.
.param PRESET=0.875 LAW=0.50 MTR=0.5 LIMCAL=0.90 COMPCAL=0.5 BIAS=0.35 BRIDGE_DRIVE=1 T1_PRIMARY_R=61
V24 VCC 0 24
VINL SL 0 SIN(0 {AMP_L} {FREQ}) AC 1
VINR SR 0 SIN(0 {AMP_R} {FREQ})
RSLH SL ILH {SOURCE/2}
RSLL ILL 0 {SOURCE/2}
RSRH SR IRH {SOURCE/2}
RSRL IRL 0 {SOURCE/2}
XLEFT ILH ILL OLH OLL VCC LCTL METERL CH609 params: CT={CTL} CR={CRL} CM={CML} CG={CGL} LT={LTL} LR={LRL} CE={CEL} LE={LEL} FAST={FASTL} PRESET={PRESET} LAW={LAW} MTR={MTR} LIMCAL={LIMCAL} COMPCAL={COMPCAL} BIAS={BIAS} BRIDGE_DRIVE={BRIDGE_DRIVE} T1_PRIMARY_R={T1_PRIMARY_R}
XRIGHT IRH IRL ORH ORL VCC RCTL METERR CH609 params: CT={CTR} CR={CRR} CM={CMR} CG={CGR} LT={LTR} LR={LRR} CE={CER} LE={LER} FAST={FASTR} PRESET={PRESET} LAW={LAW} MTR={MTR} LIMCAL={LIMCAL} COMPCAL={COMPCAL} BIAS={BIAS} BRIDGE_DRIVE={BRIDGE_DRIVE} T1_PRIMARY_R={T1_PRIMARY_R}
RRELAY_LINK LCTL RCTL {LINKED>0.5&&POWER>0.5?0.01:1e10}
RLOADL OLH OLL {LOAD}
RLOADR ORH ORL {LOAD}
RREFL OLL 0 100meg
RREFR ORL 0 100meg

.subckt CH609 INH INL OUTH OUTL VCC LINK METER params: CT=1 CR=1 CM=1 CG=1 LT=9 LR=1 CE=0 LE=0 FAST=0 PRESET=0.875 LAW=0.50 MTR=0.5 LIMCAL=0.86 COMPCAL=0.5 BIAS=0.35 BRIDGE_DRIVE=1 T1_PRIMARY_R=61
RRELAY_IH INH BOARD_IH {ACTIVE>0.5&&POWER>0.5?0.01:1e10}
RRELAY_IL INL BOARD_IL {ACTIVE>0.5&&POWER>0.5?0.01:1e10}
RINPUT_TERM BOARD_IH BOARD_IL 620
RRELAY_OH BOARD_OH OUTH {ACTIVE>0.5&&POWER>0.5?0.01:1e10}
RRELAY_OL BOARD_OL OUTL {ACTIVE>0.5&&POWER>0.5?0.01:1e10}
RRELAY_BH INH OUTH {ACTIVE>0.5&&POWER>0.5?1e10:0.01}
RRELAY_BL INL OUTL {ACTIVE>0.5&&POWER>0.5?1e10:0.01}
XBOARD BOARD_IH BOARD_IL BOARD_OH BOARD_OL VCC 0 LINK METER EX11475 params: CT={CT} CR={CR} CM={CM} CG={CG} LT={LT} LR={LR} CE={CE} LE={LE} FAST={FAST} PRESET={PRESET} LAW={LAW} MTR={MTR} LIMCAL={LIMCAL} COMPCAL={COMPCAL} BIAS={BIAS} BRIDGE_DRIVE={BRIDGE_DRIVE} T1_PRIMARY_R={T1_PRIMARY_R}
RMETER METER 0 2.2k
.ends CH609
.end
