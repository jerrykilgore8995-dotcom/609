API 550A five-position vintage engineering fixture
.include 550a.inc
.param LG=0 MG=0 HG=0 LF=1 MF=1 HF=1 LS=0 HS=0 BP=0 EQ=1 LOAD=600 AMP=1.7377 FREQ=1000
VPLUS PP 0 16
VMINUS NN 0 -16
VINL SL 0 SIN(0 {AMP} {FREQ}) AC 1
VINR SR 0 0
RSL SL ILH 40
RSR SR IRH 40
XLEFT ILH ILL OLH OLL PP NN 0 API550A params: LG={LG} MG={MG} HG={HG} LF={LF} MF={MF} HF={HF} LS={LS} HS={HS} BP={BP} EQ={EQ}
XRIGHT IRH IRL ORH ORL PP NN 0 API550A params: LG={LG} MG={MG} HG={HG} LF={LF} MF={MF} HF={HF} LS={LS} HS={HS} BP={BP} EQ={EQ}
RLOADL OLH OLL {LOAD}
RLOADR ORH ORL {LOAD}
RREFL OLL 0 100meg
RREFR ORL 0 100meg
.end
