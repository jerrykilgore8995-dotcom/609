2254 original discrete limiter/compressor fixture
.include ../../circuit/devices.inc
.include ../../circuit/switches.inc
.include parts.inc
.include iron.inc
.include b183.inc
.include l10004.inc

.options method=gear
.param AMP_L=1.095873 AMP_R=0 FREQ=1000 SOURCE=40 LOAD=600
.param ACTIVE=1 LINKED=0 POWER=1 PANELINL=1 PANELINR=1 DEESSL=0 DEESSR=0
.param CTL=1 CRL=1 CML=1 CGL=1 LTL=9 LRL=1 CEL=0 LEL=0 FASTL=0 CATKL=0
.param CTR=1 CRR=1 CMR=1 CGR=1 LTR=9 LRR=1 CER=0 LER=0 FASTR=0 CATKR=0
V24 VCC 0 24
VINL SL 0 SIN(0 {AMP_L} {FREQ}) AC 1
VINR SR 0 SIN(0 {AMP_R} {FREQ})
RSLH SL ILH {SOURCE/2}
RSLL ILL 0 {SOURCE/2}
RSRH SR IRH {SOURCE/2}
RSRL IRL 0 {SOURCE/2}
XLEFT ILH ILL OLH OLL VCC LCTL METERL CH2254 params: CT={CTL} CR={CRL} CM={CML} CG={CGL} LT={LTL} LR={LRL} CE={CEL} LE={LEL} FAST={FASTL} CATK={CATKL} PANELIN={PANELINL} DEESS={DEESSL}
XRIGHT IRH IRL ORH ORL VCC RCTL METERR CH2254 params: CT={CTR} CR={CRR} CM={CMR} CG={CGR} LT={LTR} LR={LRR} CE={CER} LE={LER} FAST={FASTR} CATK={CATKR} PANELIN={PANELINR} DEESS={DEESSR}
RRELAY_LINK LCTL RCTL {LINKED>0.5&&POWER>0.5?0.01:1e10}
RLOADL OLH OLL {LOAD}
RLOADR ORH ORL {LOAD}
RREFL OLL 0 100meg
RREFR ORL 0 100meg

.subckt CH2254 INH INL OUTH OUTL VCC LINK METER params: CT=1 CR=1 CM=1 CG=1 LT=9 LR=1 CE=0 LE=0 FAST=0 CATK=0 PANELIN=1 DEESS=0
RRELAY_IH INH BOARD_IH {ACTIVE>0.5&&POWER>0.5&&PANELIN>0.5?0.01:1e10}
RRELAY_IL INL BOARD_IL {ACTIVE>0.5&&POWER>0.5&&PANELIN>0.5?0.01:1e10}
RRELAY_OH BOARD_OH OUTH {ACTIVE>0.5&&POWER>0.5&&PANELIN>0.5?0.01:1e10}
RRELAY_OL BOARD_OL OUTL {ACTIVE>0.5&&POWER>0.5&&PANELIN>0.5?0.01:1e10}
RRELAY_BH INH OUTH {ACTIVE>0.5&&POWER>0.5&&PANELIN>0.5?1e10:0.01}
RRELAY_BL INL OUTL {ACTIVE>0.5&&POWER>0.5&&PANELIN>0.5?1e10:0.01}
XBOARD BOARD_IH BOARD_IL BOARD_OH BOARD_OL VCC 0 LINK METER L10004 params: CT={CT} CR={CR} CM={CM} CG={CG} LT={LT} LR={LR} CE={CE} LE={LE} FAST={FAST} DEESS={DEESS}
RMETER METER 0 1.1k
.ends CH2254
.end
